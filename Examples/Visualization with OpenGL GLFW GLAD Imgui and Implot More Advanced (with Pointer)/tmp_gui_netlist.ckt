C1 4 5 4.700000e-06
L1 5 0 1.000000e-02
Q1 4 3 0 npn
R1 1 3 1.000000e+04
R2 1 4 1.200000e+03
R3 2 3 1.000000e+03
V1 1 0 PULSE(0.000000e+00 5.000000e+00 0 1n 1n 1.000000e-05 2.000000e-05)
V2 2 0 PULSE(0.000000e+00 5.000000e+00 0 1n 1n 1.000000e-05 2.000000e-05)
