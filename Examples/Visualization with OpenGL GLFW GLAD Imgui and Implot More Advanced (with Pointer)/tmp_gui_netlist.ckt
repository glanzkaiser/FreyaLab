C1 4 5 4.700000e-06
C2 1 0 1.300010e+00
D1 4 1
L1 5 0 1.000000e-02
M1 5 4 0 nmos
Q1 4 3 0 npn
R1 1 3 1.000000e+04
R2 1 4 1.200000e+03
R3 2 3 1.000000e+03
R4 5 0 5.000000e+01
V1 1 0 DC -3.100000e+00
V2 2 0 DC -3.100000e+00
